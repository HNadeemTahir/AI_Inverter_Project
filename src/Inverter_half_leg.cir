* V3.0 Inverter Leg - 400V Digital Twin Master
* High-Fidelity R&D Validation

* --- 1. LIBRARY INCLUDES (Using Full Absolute Paths for Reliability) ---
.INCLUDE "e:\Google Anti Gravity NgSpice\models\tlp250h.sub"
.INCLUDE "e:\Google Anti Gravity NgSpice\models\FGY75T120SWD.lib"

* --- 2. GLOBAL POWER & CONTROL ---
V_DC_Link 400_Bus 0 400V          ; Main 400V Stage
V_12V_Bias 12V_Bias 0 12V         ; Ground-referenced 12V Supply
R_Bus_ESR 400_Bus 400_Filtered 0.05

* --- 3. PWM LOGIC (16kHz / 2.0us Dead-Time) ---
* Low-Side: On at 0us
V_PWM_LS PWM_LS 0 PULSE(0 5 0 100n 100n 29u 62.5u)
R_PWM_LS_PD PWM_LS 0 10k          ; Input Safety Pull-down

* High-Side: On at 31.5us (Includes Dead-Time)
V_PWM_HS PWM_HS 0 PULSE(0 5 31.5u 100n 100n 29u 62.5u)
R_PWM_HS_PD PWM_HS 0 10k          ; Input Safety Pull-down

* --- 4. LOW-SIDE (LS) STAGE ---
* Stage 4A: Opto-Interface
R_LS_LED PWM_LS LS_Anode 330
X_LS_Driver NC_1 LS_Anode 0 NC_2 0 LS_VO_Int LS_VO_Int 12V_Bias TLP250H

* Stage 4B: Asymmetric Gate Network (15/5.6 Ohm)
R_LS_Gate_ON LS_VO_Int LS_Gate 15
R_LS_Gate_OFF LS_VO_Int LS_Gate_Net 5.6
D_LS_Gate_Fast LS_Gate LS_Gate_Net D_1N4148
R_LS_Gate_PD LS_Gate 0 10k
D_LS_Zener 0 LS_Gate D_BZT52C15

* Stage 4C: Physical Switch
X_LS_IGBT Phase_Node LS_Gate 0 FGY75T120SWD

* --- 5. HIGH-SIDE (HS) STAGE ---
* Stage 5A: Bootstrap "Floating Tank" (47uF + 104)
D_boot 12V_Bias VCC_HS D_UF4007
C_boot_bulk VCC_HS Phase_Node 47u
C_boot_hf VCC_HS Phase_Node 0.1u

* Stage 5B: Opto-Interface
R_HS_LED PWM_HS HS_Anode 330
X_HS_Driver NC_3 HS_Anode 0 NC_4 Phase_Node HS_VO_Int HS_VO_Int VCC_HS TLP250H

* Stage 5C: Asymmetric Gate Network
R_HS_Gate_ON HS_VO_Int HS_Gate 15
R_HS_Gate_OFF HS_VO_Int HS_Gate_Net 5.6
D_HS_Gate_Fast HS_Gate HS_Gate_Net D_1N4148
R_HS_Gate_PD HS_Gate Phase_Node 10k
D_HS_Zener Phase_Node HS_Gate D_BZT52C15

* Stage 5D: Physical Switch
X_HS_IGBT 400_Filtered HS_Gate Phase_Node FGY75T120SWD

* --- 6. OUTPUT LOAD & ANALYSIS ---
R_load Phase_Node 0 40           ; 10A Heavy Test Load

* --- 7. DISCRETE MODELS ---
.model D_1N4148 D(Is=2.6n N=1.8 Rs=0.5 Tt=11n)
.model D_BZT52C15 D(Is=1.4n N=1.1 Bv=15 Ibv=1m)
.model D_UF4007 D(Is=1p N=1.5 Rs=0.1 Tt=50n)

.TRAN 1u 5m
.END
