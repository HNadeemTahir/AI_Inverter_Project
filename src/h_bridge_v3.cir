* H-Bridge Version 3.0 - High Fidelity Digital Twin
* Synchronized with dsPIC30F2010 Firmware Logic (Unipolar 16kHz)

.include ../models/tlp250h.sub
.include ../models/FGY75T120SWD.lib

.param V_bus = 400
.param V_iso = 15
.param V_logic = 5
.param F_pwm = 16k
.param F_base = 50
.param DeadTime = 2u
.param C_boot = 47u
.param R_gate = 15

* --- DC Power Section ---
V_dc DC_BUS 0 {V_bus}
C_bus DC_BUS 0 2200u IC=400
R_bus_leak DC_BUS 0 1Meg

* --- Isolated Driver Supplies ---
V_aux 15V_AUX 0 {V_iso}
* Low Side A (Q3) supply
V_iso_la Vcc_la 0 {V_iso}
* Low Side B (Q4) supply
V_iso_lb Vcc_lb 0 {V_iso}

* High Side A (Q1) Bootstrap
D_boot_a 15V_AUX Vcc_ha UF4007
C_boot_a Vcc_ha PH_A {C_boot} IC=15
* High Side B (Q2) Bootstrap
D_boot_b 15V_AUX Vcc_hb UF4007
C_boot_b Vcc_hb PH_B {C_boot} IC=15

* --- H-Bridge Power Stage ---
* Leg A
XQ1 DC_BUS G_Q1 PH_A FGY75T120SWD
XQ3 PH_A G_Q3 0 FGY75T120SWD
* Leg B
XQ2 DC_BUS G_Q2 PH_B FGY75T120SWD
XQ4 PH_B G_Q4 0 FGY75T120SWD

* --- Gate Drivers (TLP250H) ---
* HS A
XDRV_HA PWM_HA 0 Vcc_ha G_Q1_DRV PH_A tlp250h
R_g1 G_Q1_DRV G_Q1 {R_gate}
* LS A
XDRV_LA PWM_LA 0 Vcc_la G_Q3_DRV 0 tlp250h
R_g3 G_Q3_DRV G_Q3 {R_gate}
* HS B
XDRV_HB PWM_HB 0 Vcc_hb G_Q2_DRV PH_B tlp250h
R_g2 G_Q2_DRV G_Q2 {R_gate}
* LS B
XDRV_LB PWM_LB 0 Vcc_lb G_Q4_DRV 0 tlp250h
R_g4 G_Q4_DRV G_Q4 {R_gate}

* --- Shunt Resistors for Convergence ---
R_sh_a PH_A 0 1G
R_sh_b PH_B 0 1G

* --- Load ---
R_load PH_A PH_B 50

* --- MCU Control Logic (SPWM Unipolar) ---
* Emulated 50Hz Sine and 16kHz Triangle
B_sine SINE 0 V=sin(2*pi*{F_base}*time)
B_tri TRI 0 V=2*abs(v(ramp)-0.5)
V_ramp ramp 0 PULSE(0 1 0 {1/F_pwm} {1/F_pwm} 1n {1/F_pwm})

* PWM Logic with Dead-Time (Simplification for simulation)
* Pos Half: V(SINE) > 0
* Neg Half: V(SINE) < 0

* Leg A Signals
B_PWM_HA PWM_HA 0 V=(v(SINE) > 0) && (v(SINE) > v(TRI)) ? {V_logic} : 0
B_PWM_LA PWM_LA 0 V=(v(SINE) > 0) && (v(SINE) < v(TRI)) ? {V_logic} : (v(SINE) <= 0 ? {V_logic} : 0)

* Leg B Signals
B_PWM_HB PWM_HB 0 V=(v(SINE) < 0) && (-v(SINE) > v(TRI)) ? {V_logic} : 0
B_PWM_LB PWM_LB 0 V=(v(SINE) < 0) && (-v(SINE) < v(TRI)) ? {V_logic} : (v(SINE) >= 0 ? {V_logic} : 0)

* --- Standard Diode for Bootstrap ---
.model UF4007 D(Is=1n N=1.5 Rs=0.1 Cjo=20p M=0.333 Vj=0.75 Fc=0.5 Tt=50n)

* --- Simulation Control ---
.options post=1
.options method=gear
.control
  tran 100n 40m
  * Save relevant nodes
  plot v(PH_A, PH_B) title 'Output Voltage (Unipolar SPWM)'
  plot v(Vcc_ha, PH_A) title 'HS Bootstrap Voltage'
  plot v(G_Q1, PH_A) v(G_Q3) title 'Gate Signals Leg A'

  * Export for Digital Twin processing
  wrdata ../results/h_bridge_v3_results.txt v(PH_A, PH_B) v(Vcc_ha, PH_A) i(V_dc)
.endc
.end
