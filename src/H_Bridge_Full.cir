* =========================================================================
*  H-BRIDGE INVERTER DIGITAL TWIN  |  Version 6.3 (DT Compensation)
* =========================================================================
*  Author      : Nadeem Tahir (Senior Automation & Power Electronics Engineer)
*  Tools       : NgSpice 46
*  Date        : 13 April 2026
*  Simulator   : NgSpice 46+ (Spice64)
*  Hardware    : dsPIC30F2010 @ 16kHz SPWM
* -------------------------------------------------------------------------
*  DESCRIPTION:
*  High-fidelity closed-loop simulation of a single-phase H-Bridge
*  inverter driving an inductive motor load (20 Ohm / 100mH).
*  Includes PI voltage regulation with ZMPT101B sensor delay modeling.
*
*  FEATURES:
*   [1] Physical IGBT Model     : onsemi FGY75T120SWD (1200V/75A)
*   [2] Isolated Gate Drivers   : Toshiba TLP250H (with safety network)
*   [3] Closed-Loop PI Control  : Kp=0.1, Ki_eff=0.5 (continuous-time)
*   [4] ZMPT101B Sensor Delay   : 200us RC lag (real-world parity)
*   [5] Inductive Motor Load    : R=20 Ohm, L=100mH (series model)
*   [6] Gate Safety Network     : 10k pull-downs, 15V Zener clamps
*   [7] Bootstrap Supply        : UF4007 + 47uF bulk + 0.1uF HF bypass
*   [8] Dead-Time Protection    : ~2us safety gap (mirrors dsPIC DTCON1)
*   [9] DT Compensation         : Current-direction dependent (tanh sensor)
*   [10] Automated .meas Metrics : V_rms, I_peak, Power, Efficiency, Tj
*   [11] Python Batch Automation : run_simulation.py (subprocess pipeline)
*
*  FIRMWARE REFERENCE:
*   - Spwm.c   : Unipolar SPWM with THI injection
*   - mppt.c   : PI voltage control with anti-windup clamping
*   - Firmware Kp=3, Ki=1 (discrete-time, NOT same as simulation)
*
*  KNOWN LIMITATIONS:
*   - limit() function not supported in NgSpice 46 B-sources
*   - sdt() integrator function not available, replaced with G+C model
*   - .PARAM variables NOT usable inside B-source expressions (hardcode values)
*   - Peak ripple on inductive loads is physical (motor back-EMF)
* =========================================================================

* =========================================================================
*  SECTION 1 : GLOBAL ENVIRONMENT & LIBRARIES
* =========================================================================
.INCLUDE "models/tlp250h.sub"
.INCLUDE "models/FGY75T120SWD.lib"
.OPTIONS   abstol=1e-6 reltol=0.01 vntol=1e-4 chgtol=1e-14 method=gear
* DT_OFFSET = 0.05 (hardcoded below; .PARAM not supported in B-source expressions)

* =========================================================================
*  SECTION 2 : PRIMARY DC POWER STAGE (400V DC Bus)
* =========================================================================
*  V_DC_Link  : Main DC bus (direct solar panel input, DC-DC boost stage planned)
*  R_Bus_ESR  : Internal resistance for high-frequency damping
*  12V_Bias   : Auxiliary supply for TLP250H gate drivers
* -------------------------------------------------------------------------
V_DC_Link      400_Bus       0               400V
R_Bus_ESR      400_Bus       400_Filtered    0.05
V_12V_Bias     12V_Bias_Int  0               12V
R_Bias_ESR     12V_Bias_Int  12V_Bias        0.1

* =========================================================================
*  SECTION 3 : CLOSED-LOOP PI CONTROLLER (Analog-Equivalent of dsPIC)
* =========================================================================
*  Implements the dsPIC30F2010 control algorithm in analog-equivalent form.
*  Signal flow: Reference -> Error -> PI Controller -> Modulation Index
* -------------------------------------------------------------------------

* 3A. REFERENCE SIGNAL: 50Hz Sine Wave
*     Centered at 0.5V with 0.389V amplitude
*     Maps to: 0.5V = 0V output, 0.889V = +311V, 0.111V = -311V
V_Ref_Sine     Sine_V        0               SINE(0.5 0.389 50)

* 3B. CARRIER SIGNAL: 16kHz Triangle Wave
*     Period = 62.5us (matches dsPIC PTPER register)
*     Ramp: 31.25us up, 31.25us down (symmetric center-aligned)
V_Carrier      Tri_V         0               PULSE(0 1 0 31.25u 31.25u 10n 62.5u)

* 3C. PI CONTROLLER: Error Calculation & Integral Accumulator
*     Kp = 0.1 (continuous-time equivalent of firmware Kp=3)
*     Ki = G/C = 0.05/0.1 = 0.5 (continuous-time equivalent of Ki=1)
*     Note: limit() not supported in NgSpice 46, using direct expression
B_Error        SIG_ERR       0               V = V(Sine_V) - V(SNS_V_DELAYED)
G_I_Accum      0             SIG_I_TERM      SIG_ERR  0  0.05
C_I_Accum      SIG_I_TERM    0               0.1       ic=0
R_I_Bleed      SIG_I_TERM    0               1G
B_PI_Sum       SIG_PI_CORR   0               V = (V(SIG_ERR)*0.1) + V(SIG_I_TERM)

* 3D. DEAD-TIME COMPENSATION (Current-Direction Dependent)
*     Senses load current direction via V_Meter
*     Adds/subtracts compensation to modulation signal
*     DT_COMP = 0.05 (matches DT_OFFSET used in PWM comparison)
*     tanh() creates a smooth +1/-1 switch to avoid discontinuities
B_DT_Comp  DT_COMP_V  0  V = 0.05 * tanh(100 * i(V_Meter))

* 3E. UNIPOLAR SPWM MODULATION WITH DEAD-TIME PROTECTION (with DT Compensation)
*     Dead-time is implemented via triangle offset comparison:
*       HS turns ON only when: modulation > triangle + DT_OFFSET
*       LS turns ON only when: modulation < triangle - DT_OFFSET
*       Dead zone (both OFF): triangle - DT_OFFSET < mod < triangle + DT_OFFSET
*     This mirrors the dsPIC30F2010 DTCON1 register hardware protection.
*     DT_OFFSET=0.05 creates ~2us dead-time at 16kHz (62.5us period).
*
*     Positive half-cycle: Leg A switches at 16kHz, Leg B clamped LOW
*     Negative half-cycle: Leg B switches at 16kHz, Leg A clamped LOW
*     PI correction is added to the sine reference before comparison
B_Pos_Half     Pos_H         0               V = ((V(Sine_V)+V(SIG_PI_CORR)) > 0.5) ? (V(Sine_V)+V(SIG_PI_CORR)-0.5)*2 : 0
B_PWM_HS_A     PWM_HS_A      0               V = (V(SIG_Fault) > 2.5) ? 0 : ((V(Pos_H)+V(DT_COMP_V) > V(Tri_V) + 0.05) ? 5 : 0)
B_PWM_LS_A     PWM_LS_A      0               V = (V(SIG_Fault) > 2.5) ? 0 : ((V(Pos_H)+V(DT_COMP_V)  < V(Tri_V) - 0.05) ? 5 : 0)

B_Neg_Half     Neg_H         0               V = ((V(Sine_V)+V(SIG_PI_CORR)) < 0.5) ? (0.5-(V(Sine_V)+V(SIG_PI_CORR)))*2 : 0
B_PWM_HS_B     PWM_HS_B      0               V = (V(SIG_Fault) > 2.5) ? 0 : ((V(Neg_H)+V(DT_COMP_V) > V(Tri_V) + 0.05) ? 5 : 0)
B_PWM_LS_B     PWM_LS_B      0               V = (V(SIG_Fault) > 2.5) ? 0 : ((V(Neg_H)+V(DT_COMP_V) < V(Tri_V) - 0.05) ? 5 : 0)

* 3F. INPUT SAFETY: PWM Signal Pull-Downs (Hardware Default)
*     Ensures PWM signals default to LOW during startup/reset
*     Prevents spurious IGBT turn-on from floating control lines
R_PD_LS_A      PWM_LS_A      0               10k
R_PD_HS_A      PWM_HS_A      0               10k
R_PD_LS_B      PWM_LS_B      0               10k
R_PD_HS_B      PWM_HS_B      0               10k

* =========================================================================
*  SECTION 4 : H-BRIDGE LEG A (Left Side — Positive Half Cycle)
* =========================================================================

* 4A. LOW-SIDE GATE DRIVE (Leg A)
*     Signal path: PWM_LS_A -> LED -> TLP250H -> Gate Network -> IGBT
R_LS_LED_A     PWM_LS_A      LS_Anode_A      330
X_LS_Dvr_A     NC_5 LS_Anode_A 0 NC_6 0      LS_VO_A LS_VO_A 12V_Bias TLP250H
R_LS_ON_A      LS_VO_A       LS_Gate_A       15
R_LS_OFF_A     LS_VO_A       LS_G_Net_A      5.6
D_LS_Fst_A     LS_Gate_A     LS_G_Net_A      D_1N4148
R_LS_PD_A      LS_Gate_A     0               10k
D_LS_Znr_A     0             LS_Gate_A       D_BZT52C15
X_LS_IGBT_A    Phase_A       LS_Gate_A 0     FGY75T120SWD

* 4B. HIGH-SIDE GATE DRIVE (Leg A) with Bootstrap Supply
*     Bootstrap: D_bt charges C_bt_bulk when Low-Side is ON
*     C_bt_hf provides high-frequency decoupling for clean switching
D_bt_A         12V_Bias      VCC_HS_A        D_UF4007
C_bt_bulk_A    VCC_HS_A      Phase_A         47u
C_bt_hf_A      VCC_HS_A      Phase_A         0.1u
R_HS_LED_A     PWM_HS_A      HS_Anode_A      330
X_HS_Dvr_A     NC_7 HS_Anode_A 0 NC_8 Phase_A HS_VO_A HS_VO_A VCC_HS_A TLP250H
R_HS_ON_A      HS_VO_A       HS_Gate_A       15
R_HS_OFF_A     HS_VO_A       HS_G_Net_A      5.6
D_HS_Fst_A     HS_Gate_A     HS_G_Net_A      D_1N4148
R_HS_PD_A      HS_Gate_A     Phase_A         10k
D_HS_Znr_A     Phase_A       HS_Gate_A       D_BZT52C15
V_SENSE_HS_A   400_Filtered  Col_HS_A        0V
X_HS_IGBT_A    Col_HS_A      HS_Gate_A Phase_A FGY75T120SWD

* =========================================================================
*  SECTION 5 : H-BRIDGE LEG B (Right Side — Negative Half Cycle)
* =========================================================================

* 5A. LOW-SIDE GATE DRIVE (Leg B)
R_LS_LED_B     PWM_LS_B      LS_Anode_B      330
X_LS_Dvr_B     NC_1 LS_Anode_B 0 NC_2 0      LS_VO_B LS_VO_B 12V_Bias TLP250H
R_LS_ON_B      LS_VO_B       LS_Gate_B       15
R_LS_OFF_B     LS_VO_B       LS_G_Net_B      5.6
D_LS_Fst_B     LS_Gate_B     LS_G_Net_B      D_1N4148
R_LS_PD_B      LS_Gate_B     0               10k
D_LS_Znr_B     0             LS_Gate_B       D_BZT52C15
X_LS_IGBT_B    Phase_B       LS_Gate_B 0     FGY75T120SWD

* 5B. HIGH-SIDE GATE DRIVE (Leg B) with Bootstrap Supply
D_bt_B         12V_Bias      VCC_HS_B        D_UF4007
C_bt_bulk_B    VCC_HS_B      Phase_B         47u
C_bt_hf_B      VCC_HS_B      Phase_B         0.1u
R_HS_LED_B     PWM_HS_B      HS_Anode_B      330
X_HS_Dvr_B     NC_3 HS_Anode_B 0 NC_4 Phase_B HS_VO_B HS_VO_B VCC_HS_B TLP250H
R_HS_ON_B      HS_VO_B       HS_Gate_B       15
R_HS_OFF_B     HS_VO_B       HS_G_Net_B      5.6
D_HS_Fst_B     HS_Gate_B     HS_G_Net_B      D_1N4148
R_HS_PD_B      HS_Gate_B     Phase_B         10k
D_HS_Znr_B     Phase_B       HS_Gate_B       D_BZT52C15
X_HS_IGBT_B    400_Filtered  HS_Gate_B Phase_B FGY75T120SWD

* =========================================================================
*  SECTION 6 : LC OUTPUT FILTER (Dual-Coil Topology)
* =========================================================================
*  Two 3mH inductors (one per leg) with 0.1 Ohm winding ESR
*  10uF CBB/MKP film capacitor with 0.2 Ohm ESR (standard market value)
*  Differential-mode resonance: ~650Hz (below 16kHz switching)
* -------------------------------------------------------------------------

* Leg A Filter Inductor
L_Filter_A     Phase_A       Node_A_Temp     3m
R_ESR_A        Node_A_Temp   OUT_A           0.1

* Leg B Filter Inductor
L_Filter_B     Phase_B       Node_B_Temp     3m
R_ESR_B        Node_B_Temp   OUT_B           0.1

* Output Filter Capacitor (10uF CBB Film, 400VAC rated)
C_Filter       OUT_A         C_Node_Temp     10u
R_C_ESR        C_Node_Temp   OUT_B           0.2

* =========================================================================
*  SECTION 7 : LOAD MODEL (Inductive Motor — R-L Series)
* =========================================================================
*  R_Motor = 20 Ohm (stator winding resistance)
*  L_Motor = 100mH (stator winding inductance)
*  V_Meter = 0V source for current measurement: use i(V_Meter)
*  Phase lag at 50Hz: arctan(2*pi*50*0.1/20) = 57 degrees
* -------------------------------------------------------------------------
V_Meter        OUT_A         AC_Meter_In     0V
R_Motor        AC_Meter_In   AC_Motor_Int    20
L_Motor        AC_Motor_Int  OUT_B           100m

* =========================================================================
*  SECTION 8 : FEEDBACK SENSOR (Virtual ZMPT101B with Physical Delay)
* =========================================================================
*  B_SNS_V_FB : Scales 311V peak output to 0.389V peak feedback
*               Formula: V_out * (0.389/311.2) + 0.5V bias = V*0.00125+0.5
*  R/C Delay  : Models the physical ZMPT101B transformer + RC filter
*               Time constant: R*C = 2k * 100nF = 200 microseconds
*               Cutoff frequency: 1/(2*pi*R*C) = 796 Hz
* -------------------------------------------------------------------------
B_SNS_V_FB     SNS_V_FB      0               V = (V(OUT_A, OUT_B) * 0.00125) + 0.5
R_ZMPT_Delay   SNS_V_FB      SNS_V_DELAYED   2k
C_ZMPT_Delay   SNS_V_DELAYED 0               100n  ic=0.5

* =========================================================================
*  SECTION 8B : MEASUREMENT HELPER NODES (For .meas Extraction)
* =========================================================================
*  NgSpice 46 .meas directive cannot evaluate compound expressions.
*  These B-sources pre-compute measurement values on dedicated nodes.
* -------------------------------------------------------------------------
B_V_Diff   MEAS_VOUT   0   V = V(OUT_A) - V(OUT_B)
B_P_Load   MEAS_POWER  0   V = V(OUT_A, OUT_B) * i(V_Meter)
B_P_DC     MEAS_DC_PWR 0   V = V(400_Bus) * i(V_DC_Link)

* =========================================================================
*  SECTION 9 : SHORT CIRCUIT PROTECTION (CT + INT0 Hardware Topology)
* =========================================================================
*  Models physical hardware: CT -> Rectifier -> Comparator -> INT0 Latch.
*  Triggers at 50A primary current (50V across 1500-ohm burden).
* -------------------------------------------------------------------------

* 9A. CURRENT TRANSFORMER (CT) + RECTIFIER (1A Primary = 1V Secondary)
B_CT_Rect      V_CT_Sec      0    V = abs(i(L_Filter_A))

* 9B. HARDWARE COMPARATOR (Pre-Divider equivalent 50V = 50A trip)
B_COMP         SIG_COMP_TRIP 0    V = (V(V_CT_Sec) > 50) ? 5 : 0

* 9C. INT0 MCU LATCH (Fault latches instantly when comparator trips)
G_INT0_LATCH   0    SIG_INT0_CAP    SIG_COMP_TRIP 0    0.1
C_INT0         SIG_INT0_CAP    0    1u    ic=0
R_INT0_BLD     SIG_INT0_CAP    0    1G

* 9D. DIGITAL FAULT FLAG (Mimics SPWM_Stop() execution on INT0)
B_INT0_FLAG    SIG_Fault     0    V = (V(SIG_INT0_CAP) > 0.5) ? 5 : 0

* 9E. PHYSICAL SHORT CIRCUIT TEST
*     Disabled by default (1000ms). To run physical fault test, change 1000m to 25m.
S_SHORT        OUT_A    OUT_B    SC_CTRL 0    SW_SC
V_SC_CTRL      SC_CTRL  0        PULSE(0 5 1000m 1n 1n 15m 100)
.model SW_SC SW(VT=2.5 RON=0.1 ROFF=1G)

* =========================================================================
*  SECTION 10 : ELECTRO-THERMAL DYNAMICS (IGBT High-Side A)
* =========================================================================
*  Translating Thermal Physics to SPICE Electrical equivalents:
*  Power=Amps, Temp=Volts, Thermal_Mass=Farads, Thermal_Resistance=Ohms

* 10A. MEASURE INSTANTANEOUS POWER (Exact V_ce × I_collector, switching & conduction)
B_IGBT_Power   0  Thermal_Power_In   I = abs(V(Col_HS_A, Phase_A) * i(V_SENSE_HS_A))

* 10B. SILICON JUNCTION TO CASE (Internal IGBT Package)
R_Junction    Thermal_Power_In    Case_Temp     0.21
C_Junction    Thermal_Power_In    0             0.05

* 10C. THERMAL PASTE (Case to Heatsink, TO-247 with thermal grease)
R_Paste       Case_Temp           Heatsink_Temp 0.24

* 10D. MASSIVE ALUMINUM HEATSINK
R_Heatsink    Heatsink_Temp       Ambient_Temp  1.0
C_Heatsink    Heatsink_Temp       0             10.0

* 10E. AMBIENT WEATHER TEMPERATURE (45 °C Ambient Air)
V_Ambient     Ambient_Temp        0             45
.ic V(Thermal_Power_In)=45 V(Case_Temp)=45 V(Heatsink_Temp)=45

* =========================================================================
*  SECTION 11 : COMPONENT MODELS (Discrete Semiconductor Library)
* =========================================================================
.model D_1N4148   D(Is=2.6n N=1.8 Rs=0.5 Tt=11n)
.model D_BZT52C15 D(Is=1.4n N=1.1 Bv=15 Ibv=1m Rs=1)
.model D_UF4007   D(Is=1p   N=1.5 Rs=0.1 Tt=50n)

* =========================================================================
*  SECTION 12 : SIMULATION CONTROL & VERIFICATION SCRIPTS
* =========================================================================
*  Default duration is 60ms for steady-state thermal and harmonic analysis.
*  For fault validation, adjust V_SC_CTRL pulse time in Section 9E to 25ms.
*
*  NGSPICE VERIFICATION PLOTS:
*
*  1. Modulation State Crossover
*     plot v(pwm_hs_a) v(pwm_ls_a)+6 v(pwm_hs_b)+12 v(pwm_ls_b)+18 xlimit 19m 21m title "SPWM State Crossover"
*
*  2. Dead-Time Physical Validation
*     plot v(pwm_hs_a) v(pwm_ls_a) xlimit 9.00m 9.20m title "Dead-Time Validation"
*
*  3. DC Bus Energy Recovery (Freewheeling)
*     plot i(V_DC_Link) title "DC Bus Energy Flow"
*
*  4. Electro-Thermal Junction Ripple
*     plot v(Thermal_Power_In) v(Case_Temp) v(Heatsink_Temp) title "Junction Thermal Ripple"
*
*  5. Short Circuit Protection (Requires V_SC_CTRL set to 25ms)
*     plot abs(i(L_Filter_A)) v(SIG_Fault)*10 title "Hardware SC Auto-Shutdown" xlimit 24m 28m
*

* -------------------------------------------------------------------------

* =========================================================================
*  SECTION 13 : AUTOMATED MEASUREMENTS (.meas)
* =========================================================================
*  Extracted from steady-state window (20ms-60ms) to skip PI startup.
*  Used by run_simulation.py for Python batch data harvesting.
* -------------------------------------------------------------------------
.TRAN 1u 60m UIC

.meas TRAN V_out_rms RMS v(MEAS_VOUT) FROM=20m TO=60m
.meas TRAN V_out_peak MAX v(MEAS_VOUT) FROM=20m TO=60m
.meas TRAN I_load_peak MAX i(V_Meter) FROM=20m TO=60m
.meas TRAN I_load_rms RMS i(V_Meter) FROM=20m TO=60m
.meas TRAN P_load_avg AVG v(MEAS_POWER) FROM=20m TO=60m
.meas TRAN P_dc_input AVG v(MEAS_DC_PWR) FROM=20m TO=60m
.meas TRAN Tj_max MAX v(Thermal_Power_In) FROM=20m TO=60m
.meas TRAN Tj_avg AVG v(Thermal_Power_In) FROM=20m TO=60m

.END
